* Synchronous Buck Power Stage — Variable Switching DC Power Supply
* 45V DC bus -> 12V nominal, 200 kHz, open-loop duty (D = 0.28)
* Matches hardware: L2 = 100uH, C2 = 470uF (ESR 50m), IRF540N Ron = 44m
* Purpose: verify inductor ripple current, output ripple, and load-step droop
* BEFORE closing the PID loop in firmware.
*
* Run:  ngspice -b buck_powerstage.cir
* Author: Adnan Anwar Awan

* ---------------- Power stage ----------------
V1     vin  0    45

* Hi-side MOSFET modelled as switch, Ron = IRF540N RDS(on) 44 mOhm
S1     vin  sw   ghi 0   SWMOD
* Lo-side MOSFET (synchronous rectifier)
S2     sw   0    glo 0   SWMOD
* Lo-side body diode conducts during dead-time
D1     0    sw   DBODY

* Output LC filter (real parts from BOM)
L1     sw   out  100u
Resr   out  outc 0.05
C1     outc 0    470u

* Static load: 4.8 Ohm = 2.5 A at 12 V
Rload  out  0    4.8
* Load step: additional 2.5 A drawn from t = 6 ms (total 5 A = full load)
Iload  out  0    PWL(0 0  19.999m 0  20.000m 2.5)

* ---------------- Gate drive (complementary, 200 ns dead-time) ----------------
* Period 5 us. Hi-side ON 0 .. 1.40 us  (D = 0.28)
Vghi   ghi  0    PULSE(0 1 0      10n 10n 1.40u 5u)
* Lo-side ON 1.60 us .. 4.80 us  (dead-time 200 ns each edge)
Vglo   glo  0    PULSE(0 1 1.60u  10n 10n 3.20u 5u)

.model SWMOD  SW(Ron=0.044 Roff=1Meg Vt=0.5 Vh=0.05)
.model DBODY  D(Is=1e-12 Rs=0.02)

* ---------------- Analysis ----------------
.tran 50n 30m uic

.control
run
* Steady-state before load step (half load, 2.5 A)
meas tran vout_half  AVG v(out)  from=17m  to=19.9m
meas tran vrip_hi    MAX v(out)  from=19.8m to=19.9m
meas tran vrip_lo    MIN v(out)  from=19.8m to=19.9m
* Inductor current ripple at half load
meas tran il_max     MAX i(L1)   from=19.8m to=19.9m
meas tran il_min     MIN i(L1)   from=19.8m to=19.9m
* Load-step droop (2.5 A -> 5 A at 6 ms, open loop)
meas tran vout_dip   MIN v(out)  from=20.0m to=20.5m
meas tran vout_full  AVG v(out)  from=28m  to=30m
print line
.endc
.end
